`include "constants.vams"
`include "disciplines.vams"

// Two-by-two directional coupler

module DirectionalCoupler(in1, in2, out1, out2);
    input [0:1] in1, in2;
    output [0:1] out1, out2;
    optical [0:1] in1, in2, out1, out2;

    parameter real kappa = 0.5; // Power ratio

    analog begin
        OptE(out1[0]) <+ sqrt(1 - kappa) * OptE(in1[0]) + sqrt(kappa) * OptE(in2[1]);
        OptE(out1[1]) <+ sqrt(1 - kappa) * OptE(in1[1]) - sqrt(kappa) * OptE(in2[0]);
        OptE(out2[0]) <+ sqrt(1 - kappa) * OptE(in2[0]) + sqrt(kappa) * OptE(in1[1]);
        OptE(out2[1]) <+ sqrt(1 - kappa) * OptE(in2[1]) - sqrt(kappa) * OptE(in1[0]);
    end
endmodule
