`include "constants.vams"
`include "disciplines.vams"

// Optical attenuator

module Attenuator(in, out);
    input [0:1] in;
    output [0:1] out;
    optical [0:1] in, out, transfer_pol, transfer;

    parameter real attenuation = 3.0; // [dB]

    PolToCart PolToCart1(transfer_pol, transfer);
    CartMul CartMul1(transfer, in, out);

    analog begin
        OptE(transfer_pol[0]) <+ pow(10, - attenuation / 20);
        OptE(transfer_pol[1]) <+ 0;
    end
endmodule
