`include "constants.vams"
`include "disciplines.vams"

// Optical phase shifter

module PhaseShifter(in, out);
    input [0:1] in;
    output [0:1] out;
    optical [0:1] in, out, transfer_pol, transfer;

    parameter real phase = 90; // Phase delay [degree]

    PolToCart PolToCart1(transfer_pol, transfer);
    CartMul CartMul1(transfer, in, out);

    analog begin
        OptE(transfer_pol[0]) <+ 1; // Amplitude
        OptE(transfer_pol[1]) <+ (- phase / 180 * `M_PI) % (2 * `M_PI); // Angle
    end
endmodule
