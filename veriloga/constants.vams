/*
 Verilog-A definition of Mathematical and physical constants
 $RCSfile: constants.vams,v $ $Revision: 1.1 $ $Date: 2003/09/22 01:36:17 $
*/
`ifdef CONSTANTS_VAMS
`else
`define CONSTANTS_VAMS 1
// M_ indicates a mathematical constant
`define M_E        2.7182818284590452354
`define M_LOG2E    1.4426950408889634074
`define M_LOG10E   0.43429448190325182765
`define M_LN2      0.69314718055994530942
`define M_LN10     2.30258509299404568402
`define M_PI       3.14159265358979323846
`define M_TWO_PI   6.28318530717958647652
`define M_PI_2     1.57079632679489661923
`define M_PI_4     0.78539816339744830962
`define M_1_PI     0.31830988618379067154
`define M_2_PI     0.63661977236758134308
`define M_2_SQRTPI 1.12837916709551257390
`define M_SQRT2    1.41421356237309504880
`define M_SQRT1_2  0.70710678118654752440

// P_ indicates a physical constant

// charge of electron in coulombs
`define P_Q 1.6021918e-19

// speed of light in vacuum in meters/sec
`define P_C 2.997924562e8

// Boltzman's constant in joules/kelvin
`define P_K 1.3806226e-23

// Plank's constant in joules*sec
`define P_H 6.6260755e-34

// permittivity of vacuum in farads/meter
`define P_EPS0 8.85418792394420013968e-12

// permeability of vacuum in henrys/meter
`define P_U0 (4.0e-7 * `M_PI)

// zero celsius in kelvin
`define P_CELSIUS0 273.15

// reference frequency
`define F_REF (`P_C / 1550 / 1e-9)

`endif
