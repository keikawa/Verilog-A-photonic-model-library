`include "constants.vams"
`include "disciplines.vams"

// Optical one-by-two splitter

module OneTwoSplitter(in, out1, out2);
    input [0:1] in;
    output [0:1] out1, out2;
    optical [0:1] in, out1, out2;

    parameter real kappa = 0.5; // Power ratio

    analog begin
        OptE(out1[0]) <+ sqrt(kappa) * OptE(in[0]);
        OptE(out1[1]) <+ sqrt(kappa) * OptE(in[1]);
        OptE(out2[0]) <+ sqrt(1 - kappa) * OptE(in[0]);
        OptE(out2[1]) <+ sqrt(1 - kappa) * OptE(in[1]);
    end
endmodule
