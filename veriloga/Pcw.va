`include "constants.vams"
`include "disciplines.vams"

// Photonic crystal waveguide
// Currently, the only difference from 'Waveguide' is the parameters
// ToDo: Implement transmission and delay spectrum

module Pcw(in, out);
    input [0:1] in;
    output [0:1] out;
    optical [0:1] in, out, transfer_pol, transfer, out_tmp;

    parameter real length = 100e-6; // [m]
    parameter real equivalentIndex = 2.31;
    parameter real groupIndex = 20;
    parameter real loss = 2.0; // [dB/cm]
    real alpha = 23.0258509299404568 * loss;

    PolToCart PolToCart1(transfer_pol, transfer);
    CartMul CartMul1(transfer, in, out_tmp);

    analog begin
        OptE(transfer_pol[0]) <+ exp(- alpha / 2 * length); // Propagation loss
        OptE(transfer_pol[1]) <+ (- length * equivalentIndex * 2 * `M_PI * `F_REF / `P_C) % (2 * `M_PI); // Phase rotation
        OptE(out[0]) <+ absdelay(OptE(out_tmp[0]), length*groupIndex / `P_C); // Group delay
        OptE(out[1]) <+ absdelay(OptE(out_tmp[1]), length*groupIndex / `P_C); // Group delay
    end
endmodule
